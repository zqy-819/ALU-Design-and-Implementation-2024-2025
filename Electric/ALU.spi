*** SPICE deck for cell ALU{sch} from library my_device_widths
*** Created on 星期四 三月 20, 2025 18:49:26
*** Last revised on 星期六 三月 22, 2025 19:36:27
*** Written on 星期六 三月 22, 2025 19:36:34 by Electric VLSI Design System, version 9.07
*** Layout tech: mocmos, foundry MOSIS
*** UC SPICE *** , MIN_RESIST 4.0, MIN_CAPAC 0.1FF

*** SUBCIRCUIT my_device_widths__my_inv_4 FROM CELL my_inv_4{sch}
.SUBCKT my_device_widths__my_inv_4 in out
** GLOBAL gnd
** GLOBAL vdd
Mnmos-4@0 out in gnd gnd NMOS L=0.6U W=7.5U
Mpmos-4@0 out in vdd vdd PMOS L=0.6U W=9U
.ENDS my_device_widths__my_inv_4

*** SUBCIRCUIT my_device_widths__8_1MUX FROM CELL 8_1MUX{sch}
.SUBCKT my_device_widths__8_1MUX A B C I1 I2 I3 I4 I5 I6 I7 I8 OUT
** GLOBAL gnd
** GLOBAL vdd
Mnmos-4@0 I1 Abar net@1 gnd NMOS L=0.6U W=7.5U
Mnmos-4@1 net@1 Bbar net@3 gnd NMOS L=0.6U W=7.5U
Mnmos-4@2 net@3 Cbar OUT gnd NMOS L=0.6U W=7.5U
Mnmos-4@3 I2 Abar net@19 gnd NMOS L=0.6U W=7.5U
Mnmos-4@4 net@19 Bbar net@20 gnd NMOS L=0.6U W=7.5U
Mnmos-4@5 net@20 C OUT OUT NMOS L=0.6U W=7.5U
Mnmos-4@6 I3 Abar net@39 gnd NMOS L=0.6U W=7.5U
Mnmos-4@7 net@39 B net@40 gnd NMOS L=0.6U W=7.5U
Mnmos-4@8 net@40 Cbar OUT gnd NMOS L=0.6U W=7.5U
Mnmos-4@9 I4 Abar net@57 gnd NMOS L=0.6U W=7.5U
Mnmos-4@10 net@57 B net@58 gnd NMOS L=0.6U W=7.5U
Mnmos-4@11 net@58 C OUT OUT NMOS L=0.6U W=7.5U
Mnmos-4@12 I5 A net@70 gnd NMOS L=0.6U W=7.5U
Mnmos-4@13 net@70 Bbar net@71 gnd NMOS L=0.6U W=7.5U
Mnmos-4@14 net@71 Cbar OUT gnd NMOS L=0.6U W=7.5U
Mnmos-4@15 I6 A net@83 gnd NMOS L=0.6U W=7.5U
Mnmos-4@16 net@83 Bbar net@84 gnd NMOS L=0.6U W=7.5U
Mnmos-4@17 net@84 C nmos-4@17_s OUT NMOS L=0.6U W=7.5U
Mnmos-4@18 I7 A net@97 gnd NMOS L=0.6U W=7.5U
Mnmos-4@19 net@97 B net@96 gnd NMOS L=0.6U W=7.5U
Mnmos-4@20 net@96 Cbar OUT gnd NMOS L=0.6U W=7.5U
Mnmos-4@21 I8 A net@109 gnd NMOS L=0.6U W=7.5U
Mnmos-4@22 net@109 B net@110 gnd NMOS L=0.6U W=7.5U
Mnmos-4@23 net@110 C OUT gnd NMOS L=0.6U W=7.5U
Mpmos-4@0 net@5 B net@6 vdd PMOS L=0.6U W=9U
Mpmos-4@1 net@6 C OUT vdd PMOS L=0.6U W=9U
Mpmos-4@2 I1 A net@5 vdd PMOS L=0.6U W=9U
Mpmos-4@3 I2 A net@29 vdd PMOS L=0.6U W=9U
Mpmos-4@4 net@29 B net@30 vdd PMOS L=0.6U W=9U
Mpmos-4@5 net@30 Cbar OUT vdd PMOS L=0.6U W=9U
Mpmos-4@6 I3 A net@53 vdd PMOS L=0.6U W=9U
Mpmos-4@7 net@53 Bbar net@54 pmos-4@7_b PMOS L=0.6U W=9U
Mpmos-4@8 net@54 C OUT vdd PMOS L=0.6U W=9U
Mpmos-4@9 I4 A net@62 vdd PMOS L=0.6U W=9U
Mpmos-4@10 net@62 Bbar net@63 pmos-4@10_b PMOS L=0.6U W=9U
Mpmos-4@11 net@63 Cbar OUT vdd PMOS L=0.6U W=9U
Mpmos-4@12 I5 Abar net@75 vdd PMOS L=0.6U W=9U
Mpmos-4@13 net@75 B net@76 vdd PMOS L=0.6U W=9U
Mpmos-4@14 net@76 C OUT vdd PMOS L=0.6U W=9U
Mpmos-4@15 I6 Abar net@91 vdd PMOS L=0.6U W=9U
Mpmos-4@16 net@91 B net@88 vdd PMOS L=0.6U W=9U
Mpmos-4@17 net@88 Cbar OUT vdd PMOS L=0.6U W=9U
Mpmos-4@18 I7 Abar net@101 vdd PMOS L=0.6U W=9U
Mpmos-4@19 net@101 Bbar net@102 vdd PMOS L=0.6U W=9U
Mpmos-4@20 net@102 C OUT vdd PMOS L=0.6U W=9U
Mpmos-4@21 I8 Abar net@117 vdd PMOS L=0.6U W=9U
Mpmos-4@22 net@117 Bbar net@116 vdd PMOS L=0.6U W=9U
Mpmos-4@23 net@116 Cbar OUT vdd PMOS L=0.6U W=9U
Xmy_inv_4@0 A Abar my_device_widths__my_inv_4
Xmy_inv_4@1 B Bbar my_device_widths__my_inv_4
Xmy_inv_4@2 C Cbar my_device_widths__my_inv_4

* Spice Code nodes in cell cell '8_1MUX{sch}'
#VDD VDD 0 DC 5
#VINI1 I1 0 DC 0 PULSE 0 5 1N 1N 1N 50N 100N
#VINI2 I2 0 DC 0 PULSE 0 5 1N 1N 1N 150N 200N
#VINI3 I3 0 DC 0 PULSE 0 5 1N 1N 1N 250N 300N
#VINI4 I4 0 DC 0 PULSE 0 5 1N 1N 1N 350N 400N
#VINI5 I5 0 DC 0 PULSE 0 5 1N 1N 1N 450N 500N
#VINI6 I6 0 DC 0 PULSE 0 5 1N 1N 1N 550N 600N
#VINI7 I7 0 DC 0 PULSE 0 5 1N 1N 1N 650N 700N
#VINI8 I8 0 DC 0 PULSE 0 5 1N 1N 1N 750N 800N
#VINIA A 0 DC 0 PULSE 0 5 1N 1N 1N 200N 300N
#VINIB B 0 DC 0 PULSE 0 5 1N 1N 1N 100N 200N
#VINIC C 0 DC 0 PULSE 0 5 1N 1N 1N 50N 100N
#.TRAN 0 800N
.include C:\Users\R9000X\Electric\C5_models.txt
.ENDS my_device_widths__8_1MUX

*** SUBCIRCUIT my_device_widths__AND FROM CELL AND{sch}
.SUBCKT my_device_widths__AND A AandB B
** GLOBAL gnd
** GLOBAL vdd
Mnmos-4@0 net@11 A net@1 gnd NMOS L=0.6U W=7.5U
Mnmos-4@1 net@1 B gnd gnd NMOS L=0.6U W=7.5U
Mpmos-4@0 net@11 B vdd vdd PMOS L=0.6U W=9U
Mpmos-4@1 net@11 A vdd vdd PMOS L=0.6U W=9U
Xmy_inv_4@0 net@11 AandB my_device_widths__my_inv_4
.ENDS my_device_widths__AND

*** SUBCIRCUIT my_device_widths__NAND FROM CELL NAND{sch}
.SUBCKT my_device_widths__NAND A AnandB B
** GLOBAL gnd
** GLOBAL vdd
Mnmos-4@0 AnandB A net@18 gnd NMOS L=0.6U W=7.5U
Mnmos-4@1 net@18 B gnd gnd NMOS L=0.6U W=7.5U
Mpmos-4@0 AnandB B vdd vdd PMOS L=0.6U W=9U
Mpmos-4@1 AnandB A vdd vdd PMOS L=0.6U W=9U
.ENDS my_device_widths__NAND

*** SUBCIRCUIT my_device_widths__NOR FROM CELL NOR{sch}
.SUBCKT my_device_widths__NOR A AnorB B
** GLOBAL gnd
** GLOBAL vdd
Mnmos-4@0 AnorB A gnd gnd NMOS L=0.6U W=7.5U
Mnmos-4@1 AnorB B gnd gnd NMOS L=0.6U W=7.5U
Mpmos-4@0 net@52 A vdd vdd PMOS L=0.6U W=9U
Mpmos-4@1 AnorB B net@52 vdd PMOS L=0.6U W=9U
.ENDS my_device_widths__NOR

*** SUBCIRCUIT my_device_widths__OR FROM CELL OR{sch}
.SUBCKT my_device_widths__OR A AorB B
** GLOBAL gnd
** GLOBAL vdd
Mnmos-4@0 net@1 A gnd gnd NMOS L=0.6U W=7.5U
Mnmos-4@1 net@1 B gnd gnd NMOS L=0.6U W=7.5U
Mpmos-4@0 net@47 A vdd vdd PMOS L=0.6U W=9U
Mpmos-4@1 net@1 B net@47 vdd PMOS L=0.6U W=9U
Xmy_inv_4@0 net@1 AorB my_device_widths__my_inv_4
.ENDS my_device_widths__OR

*** SUBCIRCUIT my_device_widths__Three_state_gate FROM CELL Three_state_gate{sch}
.SUBCKT my_device_widths__Three_state_gate C IN OUT
** GLOBAL gnd
** GLOBAL vdd
Mnmos-4@1 IN net@58 OUT gnd NMOS L=0.6U W=7.5U
Mpmos-4@1 IN C OUT vdd PMOS L=0.6U W=9U
Xmy_inv_4@0 C net@58 my_device_widths__my_inv_4

* Spice Code nodes in cell cell 'Three_state_gate{sch}'
#VDD VDD 0 DC 5
#VIN IN 0 DC 0 PULSE 0 5 1N 1N 1N 25N 50N
#VINC C 0 DC 0 PULSE 0 5 1N 1N 1N 50N 100N
#.TRAN 0 400N
.include C:\Users\R9000X\Electric\C5_models.txt
.ENDS my_device_widths__Three_state_gate

*** SUBCIRCUIT my_device_widths__inv FROM CELL inv{sch}
.SUBCKT my_device_widths__inv in out
** GLOBAL gnd
** GLOBAL vdd
Mnmos@0 out in gnd gnd NMOS L=0.6U W=7.5U
Mpmos@0 out in vdd vdd PMOS L=0.6U W=9U
.ENDS my_device_widths__inv

*** SUBCIRCUIT my_device_widths__XNOR FROM CELL XNOR{sch}
.SUBCKT my_device_widths__XNOR A AxnorB B
** GLOBAL gnd
** GLOBAL vdd
Mnmos-4@0 net@1 B net@37 gnd NMOS L=0.6U W=7.5U
Mnmos-4@1 net@1 Bbar net@11 gnd NMOS L=0.6U W=7.5U
Mnmos-4@2 net@37 A gnd gnd NMOS L=0.6U W=7.5U
Mnmos-4@3 net@11 Abar gnd gnd NMOS L=0.6U W=7.5U
Mnmos-4@4 AxnorB net@1 gnd gnd NMOS L=0.6U W=7.5U
Mpmos-4@0 net@1 B net@16 vdd PMOS L=0.6U W=9U
Mpmos-4@1 net@16 Abar vdd vdd PMOS L=0.6U W=9U
Mpmos-4@2 net@1 Bbar net@25 vdd PMOS L=0.6U W=9U
Mpmos-4@3 net@25 A vdd vdd PMOS L=0.6U W=9U
Mpmos-4@4 AxnorB net@1 vdd vdd PMOS L=0.6U W=9U
Xinv@0 A Abar my_device_widths__inv
Xinv@1 B Bbar my_device_widths__inv
.ENDS my_device_widths__XNOR

*** SUBCIRCUIT my_device_widths__XOR FROM CELL XOR{sch}
.SUBCKT my_device_widths__XOR A B OUT
** GLOBAL gnd
** GLOBAL vdd
Mnmos-4@0 OUT B net@9 gnd NMOS L=0.6U W=7.5U
Mnmos-4@1 OUT Bbar net@35 gnd NMOS L=0.6U W=7.5U
Mnmos-4@2 net@9 A gnd gnd NMOS L=0.6U W=7.5U
Mnmos-4@3 net@35 Abar gnd gnd NMOS L=0.6U W=7.5U
Mpmos-4@0 OUT B net@44 vdd PMOS L=0.6U W=9U
Mpmos-4@1 net@44 Abar vdd vdd PMOS L=0.6U W=9U
Mpmos-4@2 OUT Bbar net@6 vdd PMOS L=0.6U W=9U
Mpmos-4@3 net@6 A vdd vdd PMOS L=0.6U W=9U
Xinv@0 A Abar my_device_widths__inv
Xinv@1 B Bbar my_device_widths__inv
.ENDS my_device_widths__XOR

.global gnd vdd

*** TOP LEVEL CELL: ALU{sch}
X_8_1MUX@0 S2 S1 S0 net@35 net@38 net@252 net@44 net@47 net@50 net@54 net@213 net@209 my_device_widths__8_1MUX
XAND@0 A net@47 B my_device_widths__AND
XAND@1 net@178 net@107 net@185 my_device_widths__AND
XAND@2 net@107 net@136 net@109 my_device_widths__AND
XAND@3 net@176 net@129 S2 my_device_widths__AND
XAND@4 net@129 net@134 S1 my_device_widths__AND
XAND@5 S0 net@169 S1 my_device_widths__AND
XAND@6 net@169 net@193 S2 my_device_widths__AND
XAND@7 net@176 net@184 net@178 my_device_widths__AND
XAND@8 net@185 net@195 net@184 my_device_widths__AND
XAND@9 net@229 net@219 net@209 my_device_widths__AND
XAND@10 S3 net@221 net@323 my_device_widths__AND
XAND@11 net@292 net@311 A my_device_widths__AND
XAND@12 net@298 net@313 A my_device_widths__AND
XAND@13 net@298 net@317 net@292 my_device_widths__AND
XAND@14 S1 net@335 S0 my_device_widths__AND
XNAND@0 A net@35 B my_device_widths__NAND
XNOR@0 A net@50 B my_device_widths__NOR
XOR@0 A net@44 B my_device_widths__OR
XOR@1 net@134 net@292 net@136 my_device_widths__OR
XOR@2 net@195 net@298 net@193 my_device_widths__OR
XOR@3 net@221 OUT net@219 my_device_widths__OR
XOR@4 net@313 net@315 net@311 my_device_widths__OR
XOR@5 net@317 Ci net@315 my_device_widths__OR
XOR@6 net@337 net@339 net@335 my_device_widths__OR
XThree_st@0 net@339 net@213 net@323 my_device_widths__Three_state_gate
XXNOR@1 S0 net@109 B my_device_widths__XNOR
XXNOR@2 A net@54 B my_device_widths__XNOR
XXOR@1 net@292 A net@141 my_device_widths__XOR
XXOR@2 net@298 net@141 net@213 my_device_widths__XOR
XXOR@3 A B net@252 my_device_widths__XOR
XXOR@4 S1 S2 net@337 my_device_widths__XOR
Xmy_inv_4@0 A net@38 my_device_widths__my_inv_4
Xmy_inv_4@1 S0 net@176 my_device_widths__my_inv_4
Xmy_inv_4@2 S1 net@178 my_device_widths__my_inv_4
Xmy_inv_4@3 S2 net@185 my_device_widths__my_inv_4
Xmy_inv_4@5 S3 net@229 my_device_widths__my_inv_4

* Spice Code nodes in cell cell 'ALU{sch}'
VDD VDD 0 DC 5
VINA A 0 DC 0 PULSE 0 5 1N 1N 1N 100N 150N
VINB B 0 DC 0 PULSE 0 5 1N 1N 1N 100N 200N
VINS0 S0 0 DC 0 PULSE 0 5 1N 1N 1N 50N 200N
VINS1 S1 0 DC 0 PULSE 0 5 1N 1N 1N 50N 150N
VINS2 S2 0 DC 0 PULSE 0 5 1N 1N 1N 50N 100N
VINS3 S3 0 DC 0 PULSE 0 5 1N 1N 1N 100N 150N
.TRAN 0 1000N
.include C:\Users\R9000X\Electric\C5_models.txt
.END
