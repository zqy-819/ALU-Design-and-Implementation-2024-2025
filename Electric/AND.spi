*** SPICE deck for cell AND{lay} from library my_device_widths
*** Created on 星期一 十一月 25, 2024 10:18:53
*** Last revised on 星期六 四月 26, 2025 11:23:41
*** Written on 星期六 四月 26, 2025 11:23:43 by Electric VLSI Design System, version 9.07
*** Layout tech: mocmos, foundry MOSIS
*** UC SPICE *** , MIN_RESIST 4.0, MIN_CAPAC 0.1FF

*** SUBCIRCUIT my_device_widths__NAND FROM CELL NAND{lay}
.SUBCKT my_device_widths__NAND A AnandB B gnd vdd
Mnmos@0 gnd B net@21 gnd NMOS L=0.6U W=7.5U AS=3.713P AD=24.525P PS=9.15U PD=37.5U
Mnmos@1 net@21 A AnandB gnd NMOS L=0.6U W=7.5U AS=9.525P AD=3.713P PS=13.3U PD=9.15U
Mpmos@0 vdd B AnandB vdd PMOS L=0.6U W=9U AS=9.525P AD=20.925P PS=13.3U PD=30.9U
Mpmos@1 AnandB A vdd vdd PMOS L=0.6U W=9U AS=20.925P AD=9.525P PS=30.9U PD=13.3U
.ENDS my_device_widths__NAND

*** SUBCIRCUIT my_device_widths__inv FROM CELL inv{lay}
.SUBCKT my_device_widths__inv gnd in out vdd
Mnmos@0 gnd in out gnd NMOS L=0.6U W=7.5U AS=13.612P AD=20.925P PS=19.8U PD=32.7U
Mpmos@0 vdd in out vdd PMOS L=0.6U W=9U AS=13.612P AD=23.4P PS=19.8U PD=35.7U
.ENDS my_device_widths__inv

*** TOP LEVEL CELL: AND{lay}
XNAND@0 A net@28 B gnd vdd my_device_widths__NAND
Xinv@0 gnd net@28 AandB vdd my_device_widths__inv

* Spice Code nodes in cell cell 'AND{lay}'
VDD VDD 0 DC 5
VINA A 0 DC 0 PULSE 0 5 1N 1N 1N 25N 50N
VINB B 0 DC 0 PULSE 0 5 1N 1N 1N 50N 100N
.TRAN 0 400N
.include C:\Users\R9000X\Electric\C5_models.txt
.END
