*** SPICE deck for cell NAND{sch} from library my_device_widths
*** Created on 星期一 十一月 11, 2024 15:45:17
*** Last revised on 星期二 五月 06, 2025 19:50:48
*** Written on 星期二 五月 06, 2025 19:50:50 by Electric VLSI Design System, version 9.07
*** Layout tech: mocmos, foundry MOSIS
*** UC SPICE *** , MIN_RESIST 4.0, MIN_CAPAC 0.1FF

.global gnd vdd

*** TOP LEVEL CELL: NAND{sch}
Mnmos-4@0 AnandB A net@18 gnd NMOS L=0.6U W=7.5U
Mnmos-4@1 net@18 B gnd gnd NMOS L=0.6U W=7.5U
Mpmos-4@0 AnandB B vdd vdd PMOS L=0.6U W=9U
Mpmos-4@1 AnandB A vdd vdd PMOS L=0.6U W=9U

* Spice Code nodes in cell cell 'NAND{sch}'
VDD VDD 0 DC 5
VINA A 0 DC 0 PULSE 0 5 1N 1N 1N 25N 50N
VINB B 0 DC 0 PULSE 0 5 1N 1N 1N 50N 100N
.TRAN 0 400N
.include C:\Users\R9000X\Electric\C5_models.txt
.END
