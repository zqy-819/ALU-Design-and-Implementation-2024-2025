*** SPICE deck for cell NOR{lay} from library my_device_widths
*** Created on 星期一 十一月 11, 2024 19:36:18
*** Last revised on 星期六 四月 26, 2025 11:31:09
*** Written on 星期六 四月 26, 2025 11:31:11 by Electric VLSI Design System, version 9.07
*** Layout tech: mocmos, foundry MOSIS
*** UC SPICE *** , MIN_RESIST 4.0, MIN_CAPAC 0.1FF

*** TOP LEVEL CELL: NOR{lay}
Mnmos@0 AnorB A gnd gnd NMOS L=0.6U W=7.5U AS=12.825P AD=13.2P PS=18.9U PD=19.3U
Mnmos@1 gnd B AnorB gnd NMOS L=0.6U W=7.5U AS=13.2P AD=12.825P PS=19.3U PD=18.9U
Mpmos@0 vdd A net@1 vdd PMOS L=0.6U W=9U AS=4.388P AD=27P PS=10.65U PD=40.5U
Mpmos@1 net@1 B AnorB vdd PMOS L=0.6U W=9U AS=13.2P AD=4.388P PS=19.3U PD=10.65U

* Spice Code nodes in cell cell 'NOR{lay}'
VDD VDD 0 DC 5
VINA A 0 DC 0 PULSE 0 5 1N 1N 1N 25N 50N
VINB B 0 DC 0 PULSE 0 5 1N 1N 1N 50N 100N
.TRAN 0 400N
.include C:\Users\R9000X\Electric\C5_models.txt
.END
