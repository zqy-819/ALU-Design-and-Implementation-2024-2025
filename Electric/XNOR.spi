*** SPICE deck for cell XNOR{lay} from library my_device_widths
*** Created on 星期一 十二月 02, 2024 10:20:06
*** Last revised on 星期六 四月 26, 2025 11:49:22
*** Written on 星期六 四月 26, 2025 11:49:24 by Electric VLSI Design System, version 9.07
*** Layout tech: mocmos, foundry MOSIS
*** UC SPICE *** , MIN_RESIST 4.0, MIN_CAPAC 0.1FF

*** SUBCIRCUIT my_device_widths__XOR FROM CELL XOR{lay}
.SUBCKT my_device_widths__XOR A B gnd OUT vdd
Mnmos@6 net@84 A gnd gnd NMOS L=0.6U W=7.5U AS=12.713P AD=13.612P PS=18U PD=19.8U
Mnmos@8 gnd A net@88 gnd NMOS L=0.6U W=7.5U AS=3.713P AD=12.713P PS=9.15U PD=18U
Mnmos@9 net@88 B OUT gnd NMOS L=0.6U W=7.5U AS=7.425P AD=3.713P PS=10.05U PD=9.15U
Mnmos@10 OUT net@116 net@123 gnd NMOS L=0.6U W=7.5U AS=3.713P AD=7.425P PS=9.15U PD=10.05U
Mnmos@11 net@123 net@84 gnd gnd NMOS L=0.6U W=7.5U AS=12.713P AD=3.713P PS=18U PD=9.15U
Mnmos@12 gnd B net@116 gnd NMOS L=0.6U W=7.5U AS=13.612P AD=12.713P PS=19.8U PD=18U
Mpmos@19 net@84 A vdd vdd PMOS L=0.6U W=9U AS=14.063P AD=13.612P PS=19.5U PD=19.8U
Mpmos@20 vdd net@84 net@108 vdd PMOS L=0.6U W=9U AS=4.388P AD=14.063P PS=10.65U PD=19.5U
Mpmos@22 OUT net@116 net@112 vdd PMOS L=0.6U W=9U AS=4.388P AD=7.425P PS=10.65U PD=10.05U
Mpmos@24 vdd B net@116 vdd PMOS L=0.6U W=9U AS=13.612P AD=14.063P PS=19.8U PD=19.5U
Mpmos@26 net@108 B OUT vdd PMOS L=0.6U W=9U AS=7.425P AD=4.388P PS=10.05U PD=10.65U
Mpmos@27 net@112 A vdd vdd PMOS L=0.6U W=9U AS=14.063P AD=4.388P PS=19.5U PD=10.65U
.ENDS my_device_widths__XOR

*** SUBCIRCUIT my_device_widths__my_inv_4 FROM CELL my_inv_4{lay}
.SUBCKT my_device_widths__my_inv_4 gnd in out vdd
Mnmos@0 gnd in out gnd NMOS L=0.6U W=7.5U AS=13.612P AD=20.925P PS=19.8U PD=32.7U
Mpmos@0 vdd in out vdd PMOS L=0.6U W=9U AS=13.612P AD=23.4P PS=19.8U PD=35.7U
.ENDS my_device_widths__my_inv_4

*** TOP LEVEL CELL: XNOR{lay}
XXOR@2 A B gnd net@7 vdd my_device_widths__XOR
Xmy_inv_4@0 gnd net@7 AxnorB vdd my_device_widths__my_inv_4

* Spice Code nodes in cell cell 'XNOR{lay}'
VDD VDD 0 DC 5
VINA A 0 DC 0 PULSE 0 5 1N 1N 1N 25N 50N
VINB B 0 DC 0 PULSE 0 5 1N 1N 1N 50N 100N
.TRAN 0 400N
.include C:\Users\R9000X\Electric\C5_models.txt
.END
