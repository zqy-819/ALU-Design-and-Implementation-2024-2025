*** SPICE deck for cell PMIRROR{sch} from library Lab
*** Created on 星期三 三月 05, 2025 17:41:02
*** Last revised on 星期三 三月 05, 2025 17:47:58
*** Written on 星期三 三月 05, 2025 17:49:04 by Electric VLSI Design System, version 9.07
*** Layout tech: mocmos, foundry MOSIS
*** UC SPICE *** , MIN_RESIST 4.0, MIN_CAPAC 0.1FF

.global gnd vdd

*** TOP LEVEL CELL: PMIRROR{sch}
MM3 vsg3 vsg3 vdd vdd PMOS L=0.6U W=6U
MM4 VD vsg3 vdd vdd PMOS L=0.6U W=24U
Rres@0 gnd vsg3 390.416k

* Spice Code nodes in cell cell 'PMIRROR{sch}'
#Zhang Qinyan
#Spice Code 19/2/2025 rev1.0
##################Library File################
.include C:\Users\R9000X\Electric\C5_models.txt
##############################################
#################The .OP operation############
.op
VDD VDD 0 DC 5
VD VD 0 DC 2V
##############################################
#################DC SWEEP#####################
#############################################
.END
