*** SPICE deck for cell Three_state_gate{sch} from library my_device_widths
*** Created on 星期六 三月 22, 2025 16:32:22
*** Last revised on 星期二 五月 06, 2025 19:47:40
*** Written on 星期二 五月 06, 2025 19:48:20 by Electric VLSI Design System, version 9.07
*** Layout tech: mocmos, foundry MOSIS
*** UC SPICE *** , MIN_RESIST 4.0, MIN_CAPAC 0.1FF

*** SUBCIRCUIT my_device_widths__my_inv_4 FROM CELL my_inv_4{sch}
.SUBCKT my_device_widths__my_inv_4 in out
** GLOBAL gnd
** GLOBAL vdd
Mnmos-4@0 out in gnd gnd NMOS L=0.6U W=7.5U
Mpmos-4@0 out in vdd vdd PMOS L=0.6U W=9U
.ENDS my_device_widths__my_inv_4

.global gnd vdd

*** TOP LEVEL CELL: Three_state_gate{sch}
Mnmos-4@1 IN net@58 OUT gnd NMOS L=0.6U W=7.5U
Mpmos-4@1 IN C OUT vdd PMOS L=0.6U W=9U
Xmy_inv_4@0 C net@58 my_device_widths__my_inv_4

* Spice Code nodes in cell cell 'Three_state_gate{sch}'
VDD VDD 0 DC 5
#TRANSIENT RESPONSE
VIN IN 0 DC 0 PULSE 0 5 1N 1N 1N 100N 200N
VC C 0 DC 0 PULSE 0 5 1N 1N 1N 50N 250N
.TRAN 0 1000N
.INCLUDE C:\Users\R9000X\Electric\C5_models.txt
.END
