*** SPICE deck for cell NAND_sim{lay} from library my_device_widths
*** Created on 星期一 十一月 11, 2024 19:30:36
*** Last revised on 星期一 十二月 02, 2024 09:54:29
*** Written on 星期六 四月 26, 2025 11:11:25 by Electric VLSI Design System, version 9.07
*** Layout tech: mocmos, foundry MOSIS
*** UC SPICE *** , MIN_RESIST 4.0, MIN_CAPAC 0.1FF

*** SUBCIRCUIT my_device_widths__NAND FROM CELL NAND{lay}
.SUBCKT my_device_widths__NAND A AnandB B gnd vdd
Mnmos@0 gnd B net@21 gnd NMOS L=0.6U W=7.5U AS=3.713P AD=24.525P PS=9.15U PD=37.5U
Mnmos@1 net@21 A AnandB gnd NMOS L=0.6U W=7.5U AS=9.525P AD=3.713P PS=13.3U PD=9.15U
Mpmos@0 vdd B AnandB vdd PMOS L=0.6U W=9U AS=9.525P AD=20.925P PS=13.3U PD=30.9U
Mpmos@1 AnandB A vdd vdd PMOS L=0.6U W=9U AS=20.925P AD=9.525P PS=30.9U PD=13.3U
.ENDS my_device_widths__NAND

*** TOP LEVEL CELL: NAND_sim{lay}
XNAND@0 in out vdd gnd vdd my_device_widths__NAND

* Spice Code nodes in cell cell 'NAND_sim{lay}'
vdd vdd 0 dc 5
vin in 0 dc 0 pulse 0 5 10n 1n
cload out 0 250fF
.tran 0 40n
.include C:\Users\R9000X\Electric\C5_models.txt
.END
