*** SPICE deck for cell RCSIM{sch} from library Lab
*** Created on 星期三 二月 12, 2025 17:41:24
*** Last revised on 星期三 三月 19, 2025 20:09:02
*** Written on 星期三 三月 19, 2025 20:09:40 by Electric VLSI Design System, version 9.07
*** Layout tech: mocmos, foundry MOSIS
*** UC SPICE *** , MIN_RESIST 4.0, MIN_CAPAC 0.1FF

*** SUBCIRCUIT Lab__CAP150fF FROM CELL CAP150fF{sch}
.SUBCKT Lab__CAP150fF P1 P2

* Spice Code nodes in cell cell 'CAP150fF{sch}'
C1 P1 P2 100fF
#CAPACITANCE BETWEEN P1 AND BULK
#C2 P1 B 10fF
.ENDS Lab__CAP150fF

.global gnd

*** TOP LEVEL CELL: RCSIM{sch}
Rres@0 OUT IN 100MEG
VACVoltag@0 IN gnd DC=1V AC=5V SIN (1V 5V 800MEG 1ns)
Xcap150fF@0 gnd OUT Lab__CAP150fF

* Spice Code nodes in cell cell 'RCSIM{sch}'
.AC DEC 100 1k 1MEG
.END
