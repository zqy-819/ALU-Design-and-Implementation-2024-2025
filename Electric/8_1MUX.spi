*** SPICE deck for cell 8_1MUX{sch} from library my_device_widths
*** Created on 星期四 三月 20, 2025 19:06:30
*** Last revised on 星期三 五月 07, 2025 11:09:54
*** Written on 星期三 五月 07, 2025 11:09:57 by Electric VLSI Design System, version 9.07
*** Layout tech: mocmos, foundry MOSIS
*** UC SPICE *** , MIN_RESIST 4.0, MIN_CAPAC 0.1FF

*** SUBCIRCUIT my_device_widths__my_inv_4 FROM CELL my_inv_4{sch}
.SUBCKT my_device_widths__my_inv_4 in out
** GLOBAL gnd
** GLOBAL vdd
Mnmos-4@0 out in gnd gnd NMOS L=0.6U W=7.5U
Mpmos-4@0 out in vdd vdd PMOS L=0.6U W=9U
.ENDS my_device_widths__my_inv_4

.global gnd vdd

*** TOP LEVEL CELL: 8_1MUX{sch}
Mnmos-4@0 I1 S2bar net@1 gnd NMOS L=0.6U W=7.5U
Mnmos-4@1 net@1 S1bar net@3 gnd NMOS L=0.6U W=7.5U
Mnmos-4@2 net@3 S0bar OUT gnd NMOS L=0.6U W=7.5U
Mnmos-4@3 I2 S2bar net@19 gnd NMOS L=0.6U W=7.5U
Mnmos-4@4 net@19 S1bar net@20 gnd NMOS L=0.6U W=7.5U
Mnmos-4@5 net@20 S0 OUT gnd NMOS L=0.6U W=7.5U
Mnmos-4@6 I3 S2bar net@39 gnd NMOS L=0.6U W=7.5U
Mnmos-4@7 net@39 S1 net@40 gnd NMOS L=0.6U W=7.5U
Mnmos-4@8 net@40 S0bar OUT gnd NMOS L=0.6U W=7.5U
Mnmos-4@9 I4 S2bar net@57 gnd NMOS L=0.6U W=7.5U
Mnmos-4@10 net@57 S1 net@58 gnd NMOS L=0.6U W=7.5U
Mnmos-4@11 net@58 S0 OUT gnd NMOS L=0.6U W=7.5U
Mnmos-4@12 I5 S2 net@70 gnd NMOS L=0.6U W=7.5U
Mnmos-4@13 net@70 S1bar net@71 gnd NMOS L=0.6U W=7.5U
Mnmos-4@14 net@71 S0bar OUT gnd NMOS L=0.6U W=7.5U
Mnmos-4@15 I6 S2 net@83 gnd NMOS L=0.6U W=7.5U
Mnmos-4@16 net@83 S1bar net@84 gnd NMOS L=0.6U W=7.5U
Mnmos-4@17 net@84 S0 OUT gnd NMOS L=0.6U W=7.5U
Mnmos-4@18 I7 S2 net@97 gnd NMOS L=0.6U W=7.5U
Mnmos-4@19 net@97 S1 net@96 gnd NMOS L=0.6U W=7.5U
Mnmos-4@20 net@96 S0bar OUT gnd NMOS L=0.6U W=7.5U
Mnmos-4@21 I8 S2 net@109 gnd NMOS L=0.6U W=7.5U
Mnmos-4@22 net@109 S1 net@110 gnd NMOS L=0.6U W=7.5U
Mnmos-4@23 net@110 S0 OUT gnd NMOS L=0.6U W=7.5U
Mpmos-4@0 net@5 S1 net@6 vdd PMOS L=0.6U W=9U
Mpmos-4@1 net@6 S0 OUT vdd PMOS L=0.6U W=9U
Mpmos-4@2 I1 S2 net@5 vdd PMOS L=0.6U W=9U
Mpmos-4@3 I2 S2 net@29 vdd PMOS L=0.6U W=9U
Mpmos-4@4 net@29 S1 net@30 vdd PMOS L=0.6U W=9U
Mpmos-4@5 net@30 S0bar OUT vdd PMOS L=0.6U W=9U
Mpmos-4@6 I3 S2 net@53 vdd PMOS L=0.6U W=9U
Mpmos-4@7 net@53 S1bar net@54 vdd PMOS L=0.6U W=9U
Mpmos-4@8 net@54 S0 OUT vdd PMOS L=0.6U W=9U
Mpmos-4@9 I4 S2 net@62 vdd PMOS L=0.6U W=9U
Mpmos-4@10 net@62 S1bar net@63 vdd PMOS L=0.6U W=9U
Mpmos-4@11 net@63 S0bar OUT vdd PMOS L=0.6U W=9U
Mpmos-4@12 I5 S2bar net@75 vdd PMOS L=0.6U W=9U
Mpmos-4@13 net@75 S1 net@76 vdd PMOS L=0.6U W=9U
Mpmos-4@14 net@76 S0 OUT vdd PMOS L=0.6U W=9U
Mpmos-4@15 I6 S2bar net@91 vdd PMOS L=0.6U W=9U
Mpmos-4@16 net@91 S1 net@88 vdd PMOS L=0.6U W=9U
Mpmos-4@17 net@88 S0bar OUT vdd PMOS L=0.6U W=9U
Mpmos-4@18 I7 S2bar net@101 vdd PMOS L=0.6U W=9U
Mpmos-4@19 net@101 S1bar net@102 vdd PMOS L=0.6U W=9U
Mpmos-4@20 net@102 S0 OUT vdd PMOS L=0.6U W=9U
Mpmos-4@21 I8 S2bar net@117 vdd PMOS L=0.6U W=9U
Mpmos-4@22 net@117 S1bar net@116 vdd PMOS L=0.6U W=9U
Mpmos-4@23 net@116 S0bar OUT vdd PMOS L=0.6U W=9U
Xmy_inv_4@0 S2 S2bar my_device_widths__my_inv_4
Xmy_inv_4@1 S1 S1bar my_device_widths__my_inv_4
Xmy_inv_4@2 S0 S0bar my_device_widths__my_inv_4

* Spice Code nodes in cell cell '8_1MUX{sch}'
VDD VDD 0 DC 5
VINI1 I1 0 DC 0 PULSE 0 5 1N 1N 1N 50N 100N
VINI2 I2 0 DC 0 PULSE 0 5 1N 1N 1N 150N 200N
VINI3 I3 0 DC 0 PULSE 0 5 1N 1N 1N 250N 300N
VINI4 I4 0 DC 0 PULSE 0 5 1N 1N 1N 350N 400N
VINI5 I5 0 DC 0 PULSE 0 5 1N 1N 1N 450N 500N
VINI6 I6 0 DC 0 PULSE 0 5 1N 1N 1N 550N 600N
VINI7 I7 0 DC 0 PULSE 0 5 1N 1N 1N 650N 700N
VINI8 I8 0 DC 0 PULSE 0 5 1N 1N 1N 750N 800N
VINIS2 S2 0 DC 0 PULSE 0 5 1N 1N 1N 200N 300N
VINIS1 S1 0 DC 0 PULSE 0 5 1N 1N 1N 100N 200N
VINIS0 S0 0 DC 0 PULSE 0 5 1N 1N 1N 50N 100N
.TRAN 0 800N
.include C:\Users\R9000X\Electric\C5_models.txt
.END
