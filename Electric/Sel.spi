*** SPICE deck for cell Sel{lay} from library my_device_widths
*** Created on 星期日 四月 27, 2025 20:56:48
*** Last revised on 星期一 四月 28, 2025 15:48:26
*** Written on 星期一 四月 28, 2025 15:48:30 by Electric VLSI Design System, version 9.07
*** Layout tech: mocmos, foundry MOSIS
*** UC SPICE *** , MIN_RESIST 4.0, MIN_CAPAC 0.1FF

*** SUBCIRCUIT my_device_widths__my_inv_4 FROM CELL my_inv_4{lay}
.SUBCKT my_device_widths__my_inv_4 gnd in out vdd
Mnmos@0 gnd in out gnd NMOS L=0.6U W=7.5U AS=13.612P AD=20.925P PS=19.8U PD=32.7U
Mpmos@0 vdd in out vdd PMOS L=0.6U W=9U AS=13.612P AD=23.4P PS=19.8U PD=35.7U
.ENDS my_device_widths__my_inv_4

*** SUBCIRCUIT my_device_widths__2_1MUX FROM CELL 2_1MUX{lay}
.SUBCKT my_device_widths__2_1MUX A B Cin gnd OUT vdd
Xmy_inv_4@0 gnd Cin net@40 vdd my_device_widths__my_inv_4
Mnmos@0 OUT net@40 A gnd NMOS L=0.6U W=7.5U AS=13.612P AD=7.425P PS=19.8U PD=10.05U
Mnmos@1 B Cin OUT gnd NMOS L=0.6U W=7.5U AS=7.425P AD=13.612P PS=10.05U PD=19.8U
Mpmos@0 OUT Cin A vdd PMOS L=0.6U W=9U AS=13.612P AD=7.425P PS=19.8U PD=10.05U
Mpmos@1 B net@40 OUT vdd PMOS L=0.6U W=9U AS=7.425P AD=13.612P PS=10.05U PD=19.8U
.ENDS my_device_widths__2_1MUX

*** SUBCIRCUIT my_device_widths__NAND FROM CELL NAND{lay}
.SUBCKT my_device_widths__NAND A AnandB B gnd vdd
Mnmos@0 gnd B net@21 gnd NMOS L=0.6U W=7.5U AS=3.713P AD=24.525P PS=9.15U PD=37.5U
Mnmos@1 net@21 A AnandB gnd NMOS L=0.6U W=7.5U AS=9.525P AD=3.713P PS=13.3U PD=9.15U
Mpmos@0 vdd B AnandB vdd PMOS L=0.6U W=9U AS=9.525P AD=20.925P PS=13.3U PD=30.9U
Mpmos@1 AnandB A vdd vdd PMOS L=0.6U W=9U AS=20.925P AD=9.525P PS=30.9U PD=13.3U
.ENDS my_device_widths__NAND

*** SUBCIRCUIT my_device_widths__inv FROM CELL inv{lay}
.SUBCKT my_device_widths__inv gnd in out vdd
Mnmos@0 gnd in out gnd NMOS L=0.6U W=7.5U AS=13.612P AD=20.925P PS=19.8U PD=32.7U
Mpmos@0 vdd in out vdd PMOS L=0.6U W=9U AS=13.612P AD=23.4P PS=19.8U PD=35.7U
.ENDS my_device_widths__inv

*** SUBCIRCUIT my_device_widths__AND FROM CELL AND{lay}
.SUBCKT my_device_widths__AND A AandB B gnd vdd
XNAND@0 A net@28 B gnd vdd my_device_widths__NAND
Xinv@0 gnd net@28 AandB vdd my_device_widths__inv
.ENDS my_device_widths__AND

*** SUBCIRCUIT my_device_widths__NOR FROM CELL NOR{lay}
.SUBCKT my_device_widths__NOR A AnorB B gnd vdd
Mnmos@0 AnorB A gnd gnd NMOS L=0.6U W=7.5U AS=12.825P AD=13.2P PS=18.9U PD=19.3U
Mnmos@1 gnd B AnorB gnd NMOS L=0.6U W=7.5U AS=13.2P AD=12.825P PS=19.3U PD=18.9U
Mpmos@0 vdd A net@1 vdd PMOS L=0.6U W=9U AS=4.388P AD=27P PS=10.65U PD=40.5U
Mpmos@1 net@1 B AnorB vdd PMOS L=0.6U W=9U AS=13.2P AD=4.388P PS=19.3U PD=10.65U
.ENDS my_device_widths__NOR

*** SUBCIRCUIT my_device_widths__OR FROM CELL OR{lay}
.SUBCKT my_device_widths__OR A AorB B gnd vdd
XNOR@0 A net@7 B gnd vdd my_device_widths__NOR
Xinv@0 gnd net@7 AorB vdd my_device_widths__inv
.ENDS my_device_widths__OR

*** SUBCIRCUIT my_device_widths__Three_state_gate FROM CELL Three_state_gate{lay}
.SUBCKT my_device_widths__Three_state_gate C gnd IN OUT vdd
Xmy_inv_4@0 gnd C net@22 vdd my_device_widths__my_inv_4
Mnmos@0 IN net@22 OUT gnd NMOS L=0.6U W=7.5U AS=13.612P AD=13.612P PS=19.8U PD=19.8U
Mpmos@0 IN C OUT vdd PMOS L=0.6U W=9U AS=13.612P AD=13.612P PS=19.8U PD=19.8U
.ENDS my_device_widths__Three_state_gate

*** TOP LEVEL CELL: Sel{lay}
X_2_1MUX@0 LU net@56 net@115 gnd OUT vdd my_device_widths__2_1MUX
XAND@0 S1 net@39 S0 gnd vdd my_device_widths__AND
XAND@1 S2 net@31 net@10 gnd vdd my_device_widths__AND
XAND@3 net@49 net@53 S3 gnd vdd my_device_widths__AND
XAND@4 S2 net@26 net@20 gnd vdd my_device_widths__AND
XAND@5 S0 net@81 S1 gnd vdd my_device_widths__AND
XAND@6 S2 net@107 net@81 gnd vdd my_device_widths__AND
XOR@1 net@26 net@37 net@31 gnd vdd my_device_widths__OR
XOR@2 net@37 net@49 net@39 gnd vdd my_device_widths__OR
XOR@3 S3 net@115 net@107 gnd vdd my_device_widths__OR
XThree_st@0 net@53 gnd AU net@56 vdd my_device_widths__Three_state_gate
Xmy_inv_4@0 gnd S0 net@10 vdd my_device_widths__my_inv_4
Xmy_inv_4@1 gnd S1 net@20 vdd my_device_widths__my_inv_4

* Spice Code nodes in cell cell 'Sel{lay}'
VDD VDD 0 DC 5
VINAU AU 0 DC 0 PULSE 0 5 1N 1N 1N 100N 150N
VINLU LU 0 DC 0 PULSE 0 5 1N 1N 1N 200N 300N
VINS0 S0 0 DC 0 PULSE 0 5 1N 1N 1N 250N 500N
VINS1 S1 0 DC 0 PULSE 0 5 1N 1N 1N 250N 500N
VINS2 S2 0 DC 0 PULSE 0 5 1N 1N 1N 250N 500N
VINS3 S3 0 DC 0 PULSE 0 5 1N 1N 1N 500N 1000N
.TRAN 0 1000N
.include C:\Users\R9000X\Electric\C5_models.txt
.END
