*** SPICE deck for cell NOR_sim{lay} from library device_widths
*** Created on 星期一 十一月 11, 2024 19:56:48
*** Last revised on 星期四 十一月 21, 2024 19:46:51
*** Written on 星期四 十一月 21, 2024 19:46:58 by Electric VLSI Design System, version 9.07
*** Layout tech: mocmos, foundry MOSIS
*** UC SPICE *** , MIN_RESIST 4.0, MIN_CAPAC 0.1FF

*** SUBCIRCUIT device_widths__NOR FROM CELL NOR{lay}
.SUBCKT device_widths__NOR A AnorB B gnd vdd
Mnmos@0 AnorB A gnd gnd NMOS L=0.6U W=7.5U AS=18P AD=18P PS=21U PD=20.5U
Mnmos@1 gnd B AnorB gnd NMOS L=0.6U W=7.5U AS=18P AD=18P PS=20.5U PD=21U
Mpmos@0 vdd A net@1 vdd PMOS L=0.6U W=9U AS=8.1P AD=33.75P PS=10.8U PD=43.5U
Mpmos@1 net@1 B AnorB vdd PMOS L=0.6U W=9U AS=18P AD=8.1P PS=20.5U PD=10.8U
.ENDS device_widths__NOR

*** TOP LEVEL CELL: NOR_sim{lay}
XNOR@0 in out gnd gnd vdd device_widths__NOR

* Spice Code nodes in cell cell 'NOR_sim{lay}'
vdd vdd 0 dc 5
vin in 0 dc 0 pulse 0 5 10n 1n
cload out 0 250fF
.tran 0 40n
.include C:\Users\R9000X\Electric\C5_models.txt
.END
