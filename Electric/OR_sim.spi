*** SPICE deck for cell OR_sim{lay} from library my_device_widths
*** Created on 星期一 十二月 02, 2024 10:08:29
*** Last revised on 星期一 十二月 02, 2024 10:11:08
*** Written on 星期一 十二月 02, 2024 10:11:11 by Electric VLSI Design System, version 9.07
*** Layout tech: mocmos, foundry MOSIS
*** UC SPICE *** , MIN_RESIST 4.0, MIN_CAPAC 0.1FF

*** SUBCIRCUIT my_device_widths__NOR FROM CELL NOR{lay}
.SUBCKT my_device_widths__NOR A AnorB B gnd vdd
Mnmos@0 AnorB A gnd gnd NMOS L=0.6U W=7.5U AS=12.825P AD=13.2P PS=18.9U PD=19.3U
Mnmos@1 gnd B AnorB gnd NMOS L=0.6U W=7.5U AS=13.2P AD=12.825P PS=19.3U PD=18.9U
Mpmos@0 vdd A net@1 vdd PMOS L=0.6U W=9U AS=4.388P AD=27P PS=10.65U PD=40.5U
Mpmos@1 net@1 B AnorB vdd PMOS L=0.6U W=9U AS=13.2P AD=4.388P PS=19.3U PD=10.65U
.ENDS my_device_widths__NOR

*** SUBCIRCUIT my_device_widths__inv FROM CELL inv{lay}
.SUBCKT my_device_widths__inv gnd in out vdd
Mnmos@0 gnd in out gnd NMOS L=0.6U W=7.5U AS=13.612P AD=20.925P PS=19.8U PD=32.7U
Mpmos@0 vdd in out vdd PMOS L=0.6U W=9U AS=13.612P AD=23.4P PS=19.8U PD=35.7U
.ENDS my_device_widths__inv

*** SUBCIRCUIT my_device_widths__OR FROM CELL OR{lay}
.SUBCKT my_device_widths__OR A AorB B gnd vdd
XNOR@0 A net@3 B gnd vdd my_device_widths__NOR
Xinv@0 gnd net@3 AorB vdd my_device_widths__inv
.ENDS my_device_widths__OR

*** TOP LEVEL CELL: OR_sim{lay}
XOR@0 in out gnd gnd vdd my_device_widths__OR

* Spice Code nodes in cell cell 'OR_sim{lay}'
vdd vdd 0 dc 5
vin in 0 dc 0 pulse 0 5 10n 1n
cload out 0 250fF
.tran 0 40n
.include C:\Users\R9000X\Electric\C5_models.txt
.END
