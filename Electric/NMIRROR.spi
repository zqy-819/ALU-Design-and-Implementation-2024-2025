*** SPICE deck for cell NMIRROR{lay} from library Lab
*** Created on 星期三 三月 19, 2025 16:15:28
*** Last revised on 星期四 三月 27, 2025 15:36:13
*** Written on 星期四 三月 27, 2025 15:36:15 by Electric VLSI Design System, version 9.07
*** Layout tech: mocmos, foundry MOSIS
*** UC SPICE *** , MIN_RESIST 4.0, MIN_CAPAC 0.1FF

*** TOP LEVEL CELL: NMIRROR{lay}
Mnmos@0 VGSREF VGSREF gnd gnd NMOS L=0.6U W=3U AS=13.5P AD=9.45P PS=23.7U PD=14.755U
Mnmos@1 VD VGSREF gnd gnd NMOS L=0.6U W=3U AS=13.5P AD=4.95P PS=23.7U PD=9.3U
Mnmos@2 VD VGSREF gnd gnd NMOS L=0.6U W=3U AS=13.5P AD=4.95P PS=23.7U PD=9.3U
Mnmos@3 VD VGSREF gnd gnd NMOS L=0.6U W=3U AS=13.5P AD=4.95P PS=23.7U PD=9.3U
Mnmos@4 VD VGSREF gnd gnd NMOS L=0.6U W=3U AS=13.5P AD=4.95P PS=23.7U PD=9.3U
Mpmos@0 VGSREF VGSREF vdd vdd PMOS L=6U W=6U AS=26.55P AD=9.45P PS=40.5U PD=14.755U
Mpmos@8 VGSREF VGSREF vdd vdd PMOS L=6U W=6U AS=26.55P AD=9.45P PS=40.5U PD=14.755U
Mpmos@9 VGSREF VGSREF vdd vdd PMOS L=6U W=6U AS=26.55P AD=9.45P PS=40.5U PD=14.755U
Mpmos@10 VGSREF VGSREF vdd vdd PMOS L=6U W=6U AS=26.55P AD=9.45P PS=40.5U PD=14.755U
Mpmos@11 VGSREF VGSREF vdd vdd PMOS L=6U W=6U AS=26.55P AD=9.45P PS=40.5U PD=14.755U
Mpmos@12 VGSREF VGSREF vdd vdd PMOS L=6U W=6U AS=26.55P AD=9.45P PS=40.5U PD=14.755U
Mpmos@13 VGSREF VGSREF vdd vdd PMOS L=6U W=6U AS=26.55P AD=9.45P PS=40.5U PD=14.755U
Mpmos@14 VGSREF VGSREF vdd vdd PMOS L=6U W=6U AS=26.55P AD=9.45P PS=40.5U PD=14.755U
Mpmos@15 VGSREF VGSREF vdd vdd PMOS L=6U W=6U AS=26.55P AD=9.45P PS=40.5U PD=14.755U
Mpmos@16 VGSREF VGSREF vdd vdd PMOS L=6U W=6U AS=26.55P AD=9.45P PS=40.5U PD=14.755U

* Spice Code nodes in cell cell 'NMIRROR{lay}'
#Zhang Qinyan
#Spice Code 26/3/2025 rev1.0
##################Library File################
.include C:\Users\R9000X\Electric\C5_models.txt
##############################################
#################The .OP operation############
.op
VDD VDD 0 DC 5
VD VD 0 DC 2V
#.DC VD 0 5 0.0001
##############################################
#################DC SWEEP#####################
#############################################
.END
