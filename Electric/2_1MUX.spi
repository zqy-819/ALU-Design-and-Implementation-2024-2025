*** SPICE deck for cell 2_1MUX{sch} from library my_device_widths
*** Created on 星期二 二月 25, 2025 18:34:20
*** Last revised on 星期四 四月 24, 2025 20:56:12
*** Written on 星期四 四月 24, 2025 20:56:14 by Electric VLSI Design System, version 9.07
*** Layout tech: mocmos, foundry MOSIS
*** UC SPICE *** , MIN_RESIST 4.0, MIN_CAPAC 0.1FF

*** SUBCIRCUIT my_device_widths__my_inv_4 FROM CELL my_inv_4{sch}
.SUBCKT my_device_widths__my_inv_4 in out
** GLOBAL gnd
** GLOBAL vdd
Mnmos-4@0 out in gnd gnd NMOS L=0.6U W=7.5U
Mpmos-4@0 out in vdd vdd PMOS L=0.6U W=9U
.ENDS my_device_widths__my_inv_4

.global gnd vdd

*** TOP LEVEL CELL: 2_1MUX{sch}
Mnmos-4@0 A net@98 OUT gnd NMOS L=0.6U W=7.5U
Mnmos-4@1 OUT Cin B gnd NMOS L=0.6U W=7.5U
Mpmos-4@0 A Cin OUT vdd PMOS L=0.6U W=9U
Mpmos-4@1 OUT net@98 B vdd PMOS L=0.6U W=9U
Xmy_inv_4@0 Cin net@98 my_device_widths__my_inv_4

* Spice Code nodes in cell cell '2_1MUX{sch}'
VDD VDD 0 DC 5
VINA A 0 DC 0 PULSE 0 5 1N 1N 1N 25N 50N
VINB B 0 DC 0 PULSE 0 5 1N 1N 1N 50N 100N
VINCin Cin 0 DC 0 PULSE 0 5 1N 1N 1N 100N 200N
.TRAN 0 400N
.include C:\Users\R9000X\Electric\C5_models.txt
.END
