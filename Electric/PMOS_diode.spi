*** SPICE deck for cell PMOS_diode{sch} from library my_device_widths
*** Created on 星期一 四月 28, 2025 16:39:03
*** Last revised on 星期一 四月 28, 2025 16:42:58
*** Written on 星期一 四月 28, 2025 16:44:40 by Electric VLSI Design System, version 9.07
*** Layout tech: mocmos, foundry MOSIS
*** UC SPICE *** , MIN_RESIST 4.0, MIN_CAPAC 0.1FF

.global gnd
*** WARNING: no power connection for P-transistor wells in cell 'PMOS_diode{sch}'

*** TOP LEVEL CELL: PMOS_diode{sch}
Mpmos-4@0 gnd gnd vin vin PMOS L=0.6U W=9U

* Spice Code nodes in cell cell 'PMOS_diode{sch}'
vin vin 0 DC 0
.dc vin 0 5 1m
.include C:\Users\R9000X\Electric\C5_models.txt
.END
