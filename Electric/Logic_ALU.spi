*** SPICE deck for cell Logic_ALU{sch} from library my_device_widths
*** Created on 星期四 四月 24, 2025 16:17:15
*** Last revised on 星期四 四月 24, 2025 20:33:15
*** Written on 星期四 四月 24, 2025 20:33:50 by Electric VLSI Design System, version 9.07
*** Layout tech: mocmos, foundry MOSIS
*** UC SPICE *** , MIN_RESIST 4.0, MIN_CAPAC 0.1FF

*** SUBCIRCUIT my_device_widths__my_inv_4 FROM CELL my_inv_4{sch}
.SUBCKT my_device_widths__my_inv_4 in out
** GLOBAL gnd
** GLOBAL vdd
Mnmos-4@0 out in gnd gnd NMOS L=0.6U W=7.5U
Mpmos-4@0 out in vdd vdd PMOS L=0.6U W=9U
.ENDS my_device_widths__my_inv_4

*** SUBCIRCUIT my_device_widths__8_1MUX FROM CELL 8_1MUX{sch}
.SUBCKT my_device_widths__8_1MUX I1 I2 I3 I4 I5 I6 I7 I8 OUT S0 S1 S2
** GLOBAL gnd
** GLOBAL vdd
Mnmos-4@0 I1 S2bar net@1 gnd NMOS L=0.6U W=7.5U
Mnmos-4@1 net@1 S1bar net@3 gnd NMOS L=0.6U W=7.5U
Mnmos-4@2 net@3 S0bar OUT gnd NMOS L=0.6U W=7.5U
Mnmos-4@3 I2 S2bar net@19 gnd NMOS L=0.6U W=7.5U
Mnmos-4@4 net@19 S1bar net@20 gnd NMOS L=0.6U W=7.5U
Mnmos-4@5 net@20 S0 OUT OUT NMOS L=0.6U W=7.5U
Mnmos-4@6 I3 S2bar net@39 gnd NMOS L=0.6U W=7.5U
Mnmos-4@7 net@39 S1 net@40 gnd NMOS L=0.6U W=7.5U
Mnmos-4@8 net@40 S0bar OUT gnd NMOS L=0.6U W=7.5U
Mnmos-4@9 I4 S2bar net@57 gnd NMOS L=0.6U W=7.5U
Mnmos-4@10 net@57 S1 net@58 gnd NMOS L=0.6U W=7.5U
Mnmos-4@11 net@58 S0 OUT OUT NMOS L=0.6U W=7.5U
Mnmos-4@12 I5 S2 net@70 gnd NMOS L=0.6U W=7.5U
Mnmos-4@13 net@70 S1bar net@71 gnd NMOS L=0.6U W=7.5U
Mnmos-4@14 net@71 S0bar OUT gnd NMOS L=0.6U W=7.5U
Mnmos-4@15 I6 S2 net@83 gnd NMOS L=0.6U W=7.5U
Mnmos-4@16 net@83 S1bar net@84 gnd NMOS L=0.6U W=7.5U
Mnmos-4@17 net@84 S0 nmos-4@17_s OUT NMOS L=0.6U W=7.5U
Mnmos-4@18 I7 S2 net@97 gnd NMOS L=0.6U W=7.5U
Mnmos-4@19 net@97 S1 net@96 gnd NMOS L=0.6U W=7.5U
Mnmos-4@20 net@96 S0bar OUT gnd NMOS L=0.6U W=7.5U
Mnmos-4@21 I8 S2 net@109 gnd NMOS L=0.6U W=7.5U
Mnmos-4@22 net@109 S1 net@110 gnd NMOS L=0.6U W=7.5U
Mnmos-4@23 net@110 S0 OUT gnd NMOS L=0.6U W=7.5U
Mpmos-4@0 net@5 S1 net@6 vdd PMOS L=0.6U W=9U
Mpmos-4@1 net@6 S0 OUT vdd PMOS L=0.6U W=9U
Mpmos-4@2 I1 S2 net@5 vdd PMOS L=0.6U W=9U
Mpmos-4@3 I2 S2 net@29 vdd PMOS L=0.6U W=9U
Mpmos-4@4 net@29 S1 net@30 vdd PMOS L=0.6U W=9U
Mpmos-4@5 net@30 S0bar OUT vdd PMOS L=0.6U W=9U
Mpmos-4@6 I3 S2 net@53 vdd PMOS L=0.6U W=9U
Mpmos-4@7 net@53 S1bar net@54 pmos-4@7_b PMOS L=0.6U W=9U
Mpmos-4@8 net@54 S0 OUT vdd PMOS L=0.6U W=9U
Mpmos-4@9 I4 S2 net@62 vdd PMOS L=0.6U W=9U
Mpmos-4@10 net@62 S1bar net@63 pmos-4@10_b PMOS L=0.6U W=9U
Mpmos-4@11 net@63 S0bar OUT vdd PMOS L=0.6U W=9U
Mpmos-4@12 I5 S2bar net@75 vdd PMOS L=0.6U W=9U
Mpmos-4@13 net@75 S1 net@76 vdd PMOS L=0.6U W=9U
Mpmos-4@14 net@76 S0 OUT vdd PMOS L=0.6U W=9U
Mpmos-4@15 I6 S2bar net@91 vdd PMOS L=0.6U W=9U
Mpmos-4@16 net@91 S1 net@88 vdd PMOS L=0.6U W=9U
Mpmos-4@17 net@88 S0bar OUT vdd PMOS L=0.6U W=9U
Mpmos-4@18 I7 S2bar net@101 vdd PMOS L=0.6U W=9U
Mpmos-4@19 net@101 S1bar net@102 vdd PMOS L=0.6U W=9U
Mpmos-4@20 net@102 S0 OUT vdd PMOS L=0.6U W=9U
Mpmos-4@21 I8 S2bar net@117 vdd PMOS L=0.6U W=9U
Mpmos-4@22 net@117 S1bar net@116 vdd PMOS L=0.6U W=9U
Mpmos-4@23 net@116 S0bar OUT vdd PMOS L=0.6U W=9U
Xmy_inv_4@0 S2 S2bar my_device_widths__my_inv_4
Xmy_inv_4@1 S1 S1bar my_device_widths__my_inv_4
Xmy_inv_4@2 S0 S0bar my_device_widths__my_inv_4

* Spice Code nodes in cell cell '8_1MUX{sch}'
#VDD VDD 0 DC 5
#VINI1 I1 0 DC 0 PULSE 0 5 1N 1N 1N 50N 100N
#VINI2 I2 0 DC 0 PULSE 0 5 1N 1N 1N 150N 200N
#VINI3 I3 0 DC 0 PULSE 0 5 1N 1N 1N 250N 300N
#VINI4 I4 0 DC 0 PULSE 0 5 1N 1N 1N 350N 400N
#VINI5 I5 0 DC 0 PULSE 0 5 1N 1N 1N 450N 500N
#VINI6 I6 0 DC 0 PULSE 0 5 1N 1N 1N 550N 600N
#VINI7 I7 0 DC 0 PULSE 0 5 1N 1N 1N 650N 700N
#VINI8 I8 0 DC 0 PULSE 0 5 1N 1N 1N 750N 800N
#VINIS2 S2 0 DC 0 PULSE 0 5 1N 1N 1N 200N 300N
#VINIS1 S1 0 DC 0 PULSE 0 5 1N 1N 1N 100N 200N
#VINIS0 S0 0 DC 0 PULSE 0 5 1N 1N 1N 50N 100N
#.TRAN 0 800N
.include C:\Users\R9000X\Electric\C5_models.txt
.ENDS my_device_widths__8_1MUX

*** SUBCIRCUIT my_device_widths__AND FROM CELL AND{sch}
.SUBCKT my_device_widths__AND A AandB B
** GLOBAL gnd
** GLOBAL vdd
Mnmos-4@0 net@11 A net@1 gnd NMOS L=0.6U W=7.5U
Mnmos-4@1 net@1 B gnd gnd NMOS L=0.6U W=7.5U
Mpmos-4@0 net@11 B vdd vdd PMOS L=0.6U W=9U
Mpmos-4@1 net@11 A vdd vdd PMOS L=0.6U W=9U
Xmy_inv_4@0 net@11 AandB my_device_widths__my_inv_4
.ENDS my_device_widths__AND

*** SUBCIRCUIT my_device_widths__NAND FROM CELL NAND{sch}
.SUBCKT my_device_widths__NAND A AnandB B
** GLOBAL gnd
** GLOBAL vdd
Mnmos-4@0 AnandB A net@18 gnd NMOS L=0.6U W=7.5U
Mnmos-4@1 net@18 B gnd gnd NMOS L=0.6U W=7.5U
Mpmos-4@0 AnandB B vdd vdd PMOS L=0.6U W=9U
Mpmos-4@1 AnandB A vdd vdd PMOS L=0.6U W=9U
.ENDS my_device_widths__NAND

*** SUBCIRCUIT my_device_widths__NOR FROM CELL NOR{sch}
.SUBCKT my_device_widths__NOR A AnorB B
** GLOBAL gnd
** GLOBAL vdd
Mnmos-4@0 AnorB A gnd gnd NMOS L=0.6U W=7.5U
Mnmos-4@1 AnorB B gnd gnd NMOS L=0.6U W=7.5U
Mpmos-4@0 net@52 A vdd vdd PMOS L=0.6U W=9U
Mpmos-4@1 AnorB B net@52 vdd PMOS L=0.6U W=9U
.ENDS my_device_widths__NOR

*** SUBCIRCUIT my_device_widths__OR FROM CELL OR{sch}
.SUBCKT my_device_widths__OR A AorB B
** GLOBAL gnd
** GLOBAL vdd
Mnmos-4@0 net@1 A gnd gnd NMOS L=0.6U W=7.5U
Mnmos-4@1 net@1 B gnd gnd NMOS L=0.6U W=7.5U
Mpmos-4@0 net@47 A vdd vdd PMOS L=0.6U W=9U
Mpmos-4@1 net@1 B net@47 vdd PMOS L=0.6U W=9U
Xmy_inv_4@0 net@1 AorB my_device_widths__my_inv_4
.ENDS my_device_widths__OR

*** SUBCIRCUIT my_device_widths__inv FROM CELL inv{sch}
.SUBCKT my_device_widths__inv in out
** GLOBAL gnd
** GLOBAL vdd
Mnmos@0 out in gnd gnd NMOS L=0.6U W=7.5U
Mpmos@0 out in vdd vdd PMOS L=0.6U W=9U
.ENDS my_device_widths__inv

*** SUBCIRCUIT my_device_widths__XNOR FROM CELL XNOR{sch}
.SUBCKT my_device_widths__XNOR A AxnorB B
** GLOBAL gnd
** GLOBAL vdd
Mnmos-4@0 net@1 B net@37 gnd NMOS L=0.6U W=7.5U
Mnmos-4@1 net@1 Bbar net@11 gnd NMOS L=0.6U W=7.5U
Mnmos-4@2 net@37 A gnd gnd NMOS L=0.6U W=7.5U
Mnmos-4@3 net@11 Abar gnd gnd NMOS L=0.6U W=7.5U
Mnmos-4@4 AxnorB net@1 gnd gnd NMOS L=0.6U W=7.5U
Mpmos-4@0 net@1 B net@16 vdd PMOS L=0.6U W=9U
Mpmos-4@1 net@16 Abar vdd vdd PMOS L=0.6U W=9U
Mpmos-4@2 net@1 Bbar net@25 vdd PMOS L=0.6U W=9U
Mpmos-4@3 net@25 A vdd vdd PMOS L=0.6U W=9U
Mpmos-4@4 AxnorB net@1 vdd vdd PMOS L=0.6U W=9U
Xinv@0 A Abar my_device_widths__inv
Xinv@1 B Bbar my_device_widths__inv
.ENDS my_device_widths__XNOR

*** SUBCIRCUIT my_device_widths__XOR FROM CELL XOR{sch}
.SUBCKT my_device_widths__XOR A B OUT
** GLOBAL gnd
** GLOBAL vdd
Mnmos-4@0 OUT B net@9 gnd NMOS L=0.6U W=7.5U
Mnmos-4@1 OUT Bbar net@35 gnd NMOS L=0.6U W=7.5U
Mnmos-4@2 net@9 A gnd gnd NMOS L=0.6U W=7.5U
Mnmos-4@3 net@35 Abar gnd gnd NMOS L=0.6U W=7.5U
Mpmos-4@0 OUT B net@44 vdd PMOS L=0.6U W=9U
Mpmos-4@1 net@44 Abar vdd vdd PMOS L=0.6U W=9U
Mpmos-4@2 OUT Bbar net@6 vdd PMOS L=0.6U W=9U
Mpmos-4@3 net@6 A vdd vdd PMOS L=0.6U W=9U
Xinv@0 A Abar my_device_widths__inv
Xinv@1 B Bbar my_device_widths__inv
.ENDS my_device_widths__XOR

.global gnd vdd

*** TOP LEVEL CELL: Logic_ALU{sch}
X_8_1MUX@1 net@20 net@23 net@26 net@30 net@37 net@34 net@31 gnd OUT S0 S1 S2 my_device_widths__8_1MUX
XAND@0 A net@37 B my_device_widths__AND
XNAND@0 A net@30 B my_device_widths__NAND
XNOR@0 A net@34 B my_device_widths__NOR
XOR@0 A net@20 B my_device_widths__OR
XXNOR@0 A net@31 B my_device_widths__XNOR
XXOR@0 A B net@26 my_device_widths__XOR
Xmy_inv_4@0 A net@23 my_device_widths__my_inv_4

* Spice Code nodes in cell cell 'Logic_ALU{sch}'
VDD VDD 0 DC 5
VINA A 0 DC 0 PULSE 0 5 1N 1N 1N 100N 150N
VINB B 0 DC 0 PULSE 0 5 1N 1N 1N 200N 300N
VINCin Cin 0 DC 0 PULSE 0 5 1N 1N 1N 150N 400N
VINS0 S0 0 DC 0 PULSE 0 5 1N 1N 1N 1N 1000N
VINS1 S1 0 DC 0 PULSE 0 5 1N 1N 1N 1N 1000N
VINS2 S2 0 DC 0 PULSE 0 5 1N 1N 1N 1000N 1000N
VINS3 S3 0 DC 0 PULSE 0 5 1N 1N 1N 1N 1000N
.TRAN 0 1000N
.include C:\Users\R9000X\Electric\C5_models.txt
.END
