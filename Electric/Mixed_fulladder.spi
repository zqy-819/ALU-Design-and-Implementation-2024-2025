*** SPICE deck for cell Mixed_fulladder{sch} from library my_device_widths
*** Created on 星期二 四月 22, 2025 10:42:48
*** Last revised on 星期二 四月 22, 2025 11:38:06
*** Written on 星期二 四月 22, 2025 11:52:12 by Electric VLSI Design System, version 9.07
*** Layout tech: mocmos, foundry MOSIS
*** UC SPICE *** , MIN_RESIST 4.0, MIN_CAPAC 0.1FF

*** SUBCIRCUIT my_device_widths__my_inv_4 FROM CELL my_inv_4{sch}
.SUBCKT my_device_widths__my_inv_4 in out
** GLOBAL gnd
** GLOBAL vdd
Mnmos-4@0 out in gnd gnd NMOS L=0.6U W=7.5U
Mpmos-4@0 out in vdd vdd PMOS L=0.6U W=9U
.ENDS my_device_widths__my_inv_4

*** SUBCIRCUIT my_device_widths__Three_state_gate FROM CELL Three_state_gate{sch}
.SUBCKT my_device_widths__Three_state_gate C IN OUT
** GLOBAL gnd
** GLOBAL vdd
Mnmos-4@1 IN net@58 OUT gnd NMOS L=0.6U W=7.5U
Mpmos-4@1 IN C OUT vdd PMOS L=0.6U W=9U
Xmy_inv_4@0 C net@58 my_device_widths__my_inv_4

* Spice Code nodes in cell cell 'Three_state_gate{sch}'
#VDD VDD 0 DC 5
#VIN IN 0 DC 0 PULSE 0 5 1N 1N 1N 25N 50N
#VINC C 0 DC 0 PULSE 0 5 1N 1N 1N 50N 100N
#.TRAN 0 400N
.include C:\Users\R9000X\Electric\C5_models.txt
.ENDS my_device_widths__Three_state_gate

.global gnd vdd

*** TOP LEVEL CELL: Mixed_fulladder{sch}
Mnmos-4@0 A B inv_AxorB gnd NMOS L=0.6U W=7.5U
Mnmos-4@1 AxorB Cin net@25 gnd NMOS L=0.6U W=7.5U
Mpmos-4@0 inv_AxorB B net@0 vdd PMOS L=0.6U W=9U
Mpmos-4@1 net@25 Cin inv_AxorB vdd PMOS L=0.6U W=9U
XThree_st@0 net@0 B inv_AxorB my_device_widths__Three_state_gate
XThree_st@1 inv_AxorB Cin net@25 my_device_widths__Three_state_gate
XThree_st@2 AxorB A Cout my_device_widths__Three_state_gate
XThree_st@3 inv_AxorB Cin Cout my_device_widths__Three_state_gate
Xmy_inv_4@0 A net@0 my_device_widths__my_inv_4
Xmy_inv_4@1 inv_AxorB AxorB my_device_widths__my_inv_4
Xmy_inv_4@3 net@25 SUM my_device_widths__my_inv_4

* Spice Code nodes in cell cell 'Mixed_fulladder{sch}'
VDD VDD 0 DC 5
#TRANSIENT RESPONSE
VINA A 0 DC 0 PULSE 0 5 1N 1N 1N 200N 400N
VINB B 0 DC 0 PULSE 0 5 1N 1N 1N 100N 200N
VCIN Cin 0 DC 0 PULSE 0 5 1N 1N 1N 400N 800N
.TRAN 0 800N
.INCLUDE C:\Users\R9000X\Electric\C5_models.txt
.END
