*** SPICE deck for cell TRANADDER{lay} from library my_device_widths
*** Created on 星期六 十二月 07, 2024 16:09:19
*** Last revised on 星期六 四月 26, 2025 18:06:06
*** Written on 星期六 四月 26, 2025 18:06:15 by Electric VLSI Design System, version 9.07
*** Layout tech: mocmos, foundry MOSIS
*** UC SPICE *** , MIN_RESIST 4.0, MIN_CAPAC 0.1FF

*** TOP LEVEL CELL: TRANADDER{lay}
Mnmos@0 net@19 A gnd gnd NMOS L=0.6U W=3U AS=10.677P AD=7.425P PS=16.118U PD=12.3U
Mnmos@1 gnd net@233 net@24 gnd NMOS L=0.6U W=3U AS=1.688P AD=10.677P PS=4.65U PD=16.118U
Mnmos@2 net@24 A net@25 gnd NMOS L=0.6U W=3U AS=1.688P AD=1.688P PS=4.65U PD=4.65U
Mnmos@3 net@25 B SUM gnd NMOS L=0.6U W=3U AS=4.05P AD=1.688P PS=6.3U PD=4.65U
Mnmos@4 SUM net@84 net@28 gnd NMOS L=0.6U W=3U AS=1.688P AD=4.05P PS=4.65U PD=6.3U
Mnmos@5 net@28 net@19 net@29 gnd NMOS L=0.6U W=3U AS=1.688P AD=1.688P PS=4.65U PD=4.65U
Mnmos@6 net@29 net@233 gnd gnd NMOS L=0.6U W=3U AS=10.677P AD=1.688P PS=16.118U PD=4.65U
Mnmos@7 gnd Cin net@32 gnd NMOS L=0.6U W=3U AS=1.688P AD=10.677P PS=4.65U PD=16.118U
Mnmos@8 net@32 net@19 net@33 gnd NMOS L=0.6U W=3U AS=1.688P AD=1.688P PS=4.65U PD=4.65U
Mnmos@9 net@33 B SUM gnd NMOS L=0.6U W=3U AS=4.05P AD=1.688P PS=6.3U PD=4.65U
Mnmos@10 SUM net@84 net@36 gnd NMOS L=0.6U W=3U AS=1.688P AD=4.05P PS=4.65U PD=6.3U
Mnmos@11 net@36 A net@37 gnd NMOS L=0.6U W=3U AS=1.688P AD=1.688P PS=4.65U PD=4.65U
Mnmos@12 net@37 Cin gnd gnd NMOS L=0.6U W=3U AS=10.677P AD=1.688P PS=16.118U PD=4.65U
Mnmos@15 gnd net@233 net@50 gnd NMOS L=0.6U W=3U AS=1.688P AD=10.677P PS=4.65U PD=16.118U
Mnmos@16 net@50 A net@51 gnd NMOS L=0.6U W=3U AS=1.688P AD=1.688P PS=4.65U PD=4.65U
Mnmos@17 net@51 net@84 COUT gnd NMOS L=0.6U W=3U AS=4.05P AD=1.688P PS=6.3U PD=4.65U
Mnmos@18 COUT B net@55 gnd NMOS L=0.6U W=3U AS=1.688P AD=4.05P PS=4.65U PD=6.3U
Mnmos@19 net@55 net@19 net@56 gnd NMOS L=0.6U W=3U AS=1.688P AD=1.688P PS=4.65U PD=4.65U
Mnmos@20 net@56 net@233 gnd gnd NMOS L=0.6U W=3U AS=10.677P AD=1.688P PS=16.118U PD=4.65U
Mnmos@21 gnd Cin net@60 gnd NMOS L=0.6U W=3U AS=1.688P AD=10.677P PS=4.65U PD=16.118U
Mnmos@22 net@60 net@19 net@61 gnd NMOS L=0.6U W=3U AS=1.688P AD=1.688P PS=4.65U PD=4.65U
Mnmos@23 net@61 net@84 COUT gnd NMOS L=0.6U W=3U AS=4.05P AD=1.688P PS=6.3U PD=4.65U
Mnmos@24 COUT net@84 net@65 gnd NMOS L=0.6U W=3U AS=1.688P AD=4.05P PS=4.65U PD=6.3U
Mnmos@25 net@65 net@19 net@66 gnd NMOS L=0.6U W=3U AS=1.688P AD=1.688P PS=4.65U PD=4.65U
Mnmos@26 net@66 net@233 gnd gnd NMOS L=0.6U W=3U AS=10.677P AD=1.688P PS=16.118U PD=4.65U
Mnmos@28 gnd Cin net@233 gnd NMOS L=0.6U W=3U AS=7.425P AD=10.677P PS=12.3U PD=16.118U
Mnmos@29 gnd B net@84 gnd NMOS L=0.6U W=3U AS=7.425P AD=10.677P PS=12.3U PD=16.118U
Mpmos@0 net@19 A vdd vdd PMOS L=0.6U W=6U AS=13.582P AD=7.425P PS=19.391U PD=12.3U
Mpmos@1 vdd net@233 net@16 vdd PMOS L=0.6U W=6U AS=3.038P AD=13.582P PS=7.65U PD=19.391U
Mpmos@2 net@16 A net@0 vdd PMOS L=0.6U W=6U AS=3.038P AD=3.038P PS=7.65U PD=7.65U
Mpmos@3 net@0 B SUM vdd PMOS L=0.6U W=6U AS=4.05P AD=3.038P PS=6.3U PD=7.65U
Mpmos@4 SUM net@84 net@15 vdd PMOS L=0.6U W=6U AS=3.038P AD=4.05P PS=7.65U PD=6.3U
Mpmos@5 net@15 net@19 net@14 vdd PMOS L=0.6U W=6U AS=3.038P AD=3.038P PS=7.65U PD=7.65U
Mpmos@6 net@14 net@233 vdd vdd PMOS L=0.6U W=6U AS=13.582P AD=3.038P PS=19.391U PD=7.65U
Mpmos@7 vdd Cin net@12 vdd PMOS L=0.6U W=6U AS=3.038P AD=13.582P PS=7.65U PD=19.391U
Mpmos@8 net@12 net@19 net@6 vdd PMOS L=0.6U W=6U AS=3.038P AD=3.038P PS=7.65U PD=7.65U
Mpmos@9 net@6 B SUM vdd PMOS L=0.6U W=6U AS=4.05P AD=3.038P PS=6.3U PD=7.65U
Mpmos@10 SUM net@84 net@9 vdd PMOS L=0.6U W=6U AS=3.038P AD=4.05P PS=7.65U PD=6.3U
Mpmos@11 net@9 A net@11 vdd PMOS L=0.6U W=6U AS=3.038P AD=3.038P PS=7.65U PD=7.65U
Mpmos@12 net@11 Cin vdd vdd PMOS L=0.6U W=6U AS=13.582P AD=3.038P PS=19.391U PD=7.65U
Mpmos@15 vdd net@233 net@79 vdd PMOS L=0.6U W=6U AS=3.038P AD=13.582P PS=7.65U PD=19.391U
Mpmos@16 net@79 A net@41 vdd PMOS L=0.6U W=6U AS=3.038P AD=3.038P PS=7.65U PD=7.65U
Mpmos@17 net@41 net@84 COUT vdd PMOS L=0.6U W=6U AS=4.05P AD=3.038P PS=6.3U PD=7.65U
Mpmos@18 COUT B net@78 vdd PMOS L=0.6U W=6U AS=3.038P AD=4.05P PS=7.65U PD=6.3U
Mpmos@19 net@78 net@19 net@77 vdd PMOS L=0.6U W=6U AS=3.038P AD=3.038P PS=7.65U PD=7.65U
Mpmos@20 net@77 net@233 vdd vdd PMOS L=0.6U W=6U AS=13.582P AD=3.038P PS=19.391U PD=7.65U
Mpmos@21 vdd Cin net@75 vdd PMOS L=0.6U W=6U AS=3.038P AD=13.582P PS=7.65U PD=19.391U
Mpmos@22 net@75 net@19 net@72 vdd PMOS L=0.6U W=6U AS=3.038P AD=3.038P PS=7.65U PD=7.65U
Mpmos@23 net@72 net@84 COUT vdd PMOS L=0.6U W=6U AS=4.05P AD=3.038P PS=6.3U PD=7.65U
Mpmos@24 COUT net@84 net@74 vdd PMOS L=0.6U W=6U AS=3.038P AD=4.05P PS=7.65U PD=6.3U
Mpmos@25 net@74 net@19 net@64 vdd PMOS L=0.6U W=6U AS=3.038P AD=3.038P PS=7.65U PD=7.65U
Mpmos@26 net@64 net@233 vdd vdd PMOS L=0.6U W=6U AS=13.582P AD=3.038P PS=19.391U PD=7.65U
Mpmos@28 vdd Cin net@233 vdd PMOS L=0.6U W=6U AS=7.425P AD=13.582P PS=12.3U PD=19.391U
Mpmos@29 vdd B net@84 vdd PMOS L=0.6U W=6U AS=7.425P AD=13.582P PS=12.3U PD=19.391U

* Spice Code nodes in cell cell 'TRANADDER{lay}'
VDD VDD 0 DC 5
#TRANSIENT RESPONSE
VINA A 0 DC 0 PULSE 0 5 1N 1N 1N 200N 400N
VINB B 0 DC 0 PULSE 0 5 1N 1N 1N 100N 200N
VCIN Cin 0 DC 0 PULSE 0 5 1N 1N 1N 400N 800N
.TRAN 0 800N
.INCLUDE C:\Users\R9000X\Electric\C5_models.txt
.END
